* NGSPICE file created from ota_cc.ext - technology: sky130A

.subckt ota_cc inp inn out vb vdd vss
X0 out inn a_n58_0# vdd sky130_fd_pr__pfet_01v8_lvt ad=2.03 pd=14.58 as=2.03 ps=14.58 w=7 l=20
X1 a_4000_0# a_4000_0# vss vss sky130_fd_pr__nfet_01v8 ad=0.87 pd=6.58 as=0.87 ps=6.58 w=3 l=8
X2 a_4000_0# inp a_n58_0# vdd sky130_fd_pr__pfet_01v8_lvt ad=2.03 pd=14.58 as=2.03 ps=14.58 w=7 l=20
X3 a_n58_0# vb vdd vdd sky130_fd_pr__pfet_01v8_lvt ad=2.03 pd=14.58 as=2.03 ps=14.58 w=7 l=20
X4 out inn a_n58_0# vdd sky130_fd_pr__pfet_01v8_lvt ad=2.03 pd=14.58 as=2.03 ps=14.58 w=7 l=20
X5 out inp a_n58_0# vdd sky130_fd_pr__pfet_01v8_lvt ad=2.03 pd=14.58 as=2.03 ps=14.58 w=7 l=20
X6 a_4000_0# inp a_n58_0# vdd sky130_fd_pr__pfet_01v8_lvt ad=2.03 pd=14.58 as=2.03 ps=14.58 w=7 l=20
X7 out a_4000_0# vss vss sky130_fd_pr__nfet_01v8 ad=0.87 pd=6.58 as=0.87 ps=6.58 w=3 l=8
X8 out inn a_n58_0# vdd sky130_fd_pr__pfet_01v8_lvt ad=2.03 pd=14.58 as=2.03 ps=14.58 w=7 l=20
X9 a_4000_0# inn a_n58_0# vdd sky130_fd_pr__pfet_01v8_lvt ad=2.03 pd=14.58 as=2.03 ps=14.58 w=7 l=20
X10 a_4000_0# inp a_n58_0# vdd sky130_fd_pr__pfet_01v8_lvt ad=2.03 pd=14.58 as=2.03 ps=14.58 w=7 l=20
C0 a_n58_0# a_4000_0# 7.20387f
C1 a_n58_0# vdd 14.5941f
C2 a_n58_0# inp 1.59933f
C3 a_n58_0# inn 1.60426f
C4 a_n58_0# vb 0.35089f
C5 a_n58_0# out 0.97732f
C6 a_4000_0# vdd 5.16989f
C7 a_4000_0# inp 1.06953f
C8 a_4000_0# inn 0.47809f
C9 a_4000_0# vb 0.01117f
C10 a_4000_0# out 8.51306f
C11 vdd inp 22.6168f
C12 vdd inn 29.2587f
C13 vdd vb 5.45493f
C14 vdd out 6.65043f
C15 inp inn 13.2881f
C16 inp out 1.41495f
C17 inn vb 1.46442f
C18 inn out 2.11346f
C19 vb out 0.00677f
C20 out vss 2.64214f
C21 vb vss 0.14873f
C22 inn vss 1.1995f
C23 inp vss 1.6124f
C24 vdd vss 0.41943p
C25 a_4000_0# vss 6.15351f
C26 a_n58_0# vss 0.39729f
.ends
